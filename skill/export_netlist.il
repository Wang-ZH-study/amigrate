;; export_netlist.il — 从 port_pilot/OPA_D/schematic 导出 Spectre 网表
;; 用法：cd /home/IC && timeout 180 virtuoso -nograph < /tmp/export_netlist.il
(printf "\n=== EXPORT START\n")

(let (cv p)
  (setq cv (dbOpenCellViewByType "port_pilot" "OPA_D" "schematic" "schematic" "r"))
  (if (null cv)
      (printf "ERROR: 打不开 port_pilot/OPA_D/schematic\n")
      (progn
        (setq p (outfile "/home/IC/port_pilot/opa_d_export.scs" "w"))
        (fprintf p "// exported from port_pilot/OPA_D/schematic\n")
        (fprintf p "simulator lang=spectre\n")
        (fprintf p "global 0\n\n")
        (fprintf p "subckt OPA_D")
        (foreach term cv~>terminals
          (fprintf p " %s" term~>name)
        )
        (fprintf p "\n")
        (foreach inst cv~>instances
          (let (mname w l fingers m termNames)
            (setq mname inst~>master~>cellName)
            (setq w (dbGet inst "w"))
            (setq l (dbGet inst "l"))
            (setq fingers (dbGet inst "fingers"))
            (setq m (dbGet inst "m"))
            (setq termNames nil)
            (foreach it inst~>instTerms
              (setq termNames (cons (list it~>name (if it~>net it~>net~>name "?")) termNames))
            )
            (setq terminalMap termNames)
            ;; MOS 按 D G S B 顺序；其它按名字排序
            (setq termNames nil)
            (foreach pn (list "D" "G" "S" "B")
              (let (hit)
                (setq hit (assoc pn terminalMap))
                (when hit (setq termNames (cons (cadr hit) termNames)))
              )
            )
            (setq termNames (reverse termNames))
            ;; 非 MOS（电阻/电容）：按原顺序输出全部端子
            (when (null termNames)
              (foreach pair terminalMap
                (setq termNames (cons (cadr pair) termNames))
              )
              (setq termNames (reverse termNames))
            )
            (cond
              ((member mname (list "n33" "p33" "n12" "p12"))
               (fprintf p "    %s (" inst~>name)
               (foreach tn termNames (fprintf p "%s " tn))
               (fprintf p ") %s w=%s l=%s" mname w l)
               (when (and fingers (neq fingers "1"))
                 (fprintf p " fingers=%s" fingers))
               (when (and m (neq m "1"))
                 (fprintf p " m=%s" m))
               (fprintf p "\n")
              )
              ((equal mname "res")
               (fprintf p "    %s (" inst~>name)
               (foreach tn termNames (fprintf p "%s " tn))
               (fprintf p ") resistor r=%s\n" (dbGet inst "r"))
              )
              ((equal mname "cap")
               (fprintf p "    %s (" inst~>name)
               (foreach tn termNames (fprintf p "%s " tn))
               (fprintf p ") capacitor c=%s\n" (dbGet inst "c"))
              )
              (t
               (fprintf p "    // skipped %s master=%s\n" inst~>name mname)
              )
            )
          )
        )
        (fprintf p "ends OPA_D\n")
        (close p)
        (printf "written /home/IC/port_pilot/opa_d_export.scs\n")
      )
  )
)

(printf "=== EXPORT DONE\n")
(exit)
